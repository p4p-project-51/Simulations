# Ansys Electronics Desktop project, version 2023.2
materials:
  vacuum: permittivity=1
  NdFe35 North: permittivity=1 permeability=1.0997785 conductivity=625000 magnetic_coercivity{Magnitude=-890000A_per_meter DirComp1=0 DirComp2=0 DirComp3=1} lande_g_factor=2
  NdFe35: permittivity=1 permeability=1.0997785 conductivity=625000 magnetic_coercivity{Magnitude=-890000A_per_meter DirComp1=1 DirComp2=0 DirComp3=0} lande_g_factor=2
  NdFe35 South: permittivity=1 permeability=1.0997785 conductivity=625000 magnetic_coercivity{Magnitude=-890000A_per_meter DirComp1=0 DirComp2=0 DirComp3=1} lande_g_factor=2
  NdFe30: permittivity=1 permeability=1.044573 conductivity=625000 magnetic_coercivity{Magnitude=-838000A_per_meter DirComp1=1 DirComp2=0 DirComp3=0} lande_g_factor=2
  NdFe52 (Project#51): permittivity=1 permeability=1.0997785 conductivity=625000 magnetic_coercivity{Magnitude=-971000A_per_meter DirComp1=0 DirComp2=0 DirComp3=1} lande_g_factor=2
  copper: permeability=0.999991 conductivity=58000000
  HDPE plastic: permittivity=2.3 dielectric_loss_tangent=0.0005

design Maxwell3DDesign1 (Maxwell 3D, Magnetostatic, model units mm)
geometry:
  Box1 [vacuum] = box(corner=(-200mm, -200mm, -200mm), size=(400mm, 400mm, 400mm))
  coordinate_system RelativeCS2 = origin=(16.963569mm, -16.333797mm, -5.7150732mm) x=(1mm, 0mm, 0mm) y=(0mm, 1mm, 0mm)
  Rectangle1 = rectangle(corner=(0mm, 0mm, 0mm), x_size=18mm, y_size=33.5mm) in RelativeCS2
  MHDPump [HDPE plastic] = imported_body(H:\2025\ELECTENG 700AB Part IV Project\MHD Pump Mk2.x_t)
  barMagnet, barMagnet_1 [NdFe52 (Project#51)] = imported_body(H:\2025\ELECTENG 700AB Part IV Project\MHD Pump Mk2.x_t)
  copperElectrode [copper] = imported_body(H:\2025\ELECTENG 700AB Part IV Project\MHD Pump Mk2.x_t)
  barMagnet_2 [NdFe52 (Project#51)] = imported_body(H:\2025\ELECTENG 700AB Part IV Project\MHD Pump Mk2.x_t)
  copperElectrode_1 [copper] = imported_body(H:\2025\ELECTENG 700AB Part IV Project\MHD Pump Mk2.x_t)
  barMagnet_3 [NdFe52 (Project#51)] = imported_body(H:\2025\ELECTENG 700AB Part IV Project\MHD Pump Mk2.x_t)
  coordinate_system RelativeCS1 = origin=(6.9635689mm, -16.333797mm, -7.7150732mm) x=(1mm, 0mm, 0mm) y=(0mm, 1mm, 0mm)
  group MHDPumpMk2 = MHDPump, barMagnet, barMagnet_1, copperElectrode, barMagnet_2, copperElectrode_1, barMagnet_3
mesh:
  initial mesh: GlobalCurvilinear{Apply}
setups:
  Solver: Magnetostatic MaximumPasses=10 MinimumPasses=2 MinimumConvergedPasses=1 PercentRefinement=30 PercentError=5 NonLinearResidual=0.001
field plots:
  Mag_B1: B over Rectangle1.face on Solver : LastAdaptive
