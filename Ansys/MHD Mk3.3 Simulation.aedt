# Ansys Electronics Desktop project, version 2023.2
materials:
  vacuum: permittivity=1
  NdFe35 North: permittivity=1 permeability=1.0997785 conductivity=625000 magnetic_coercivity{Magnitude=-890000A_per_meter DirComp1=0 DirComp2=0 DirComp3=1} lande_g_factor=2
  NdFe35: permittivity=1 permeability=1.0997785 conductivity=625000 magnetic_coercivity{Magnitude=-890000A_per_meter DirComp1=1 DirComp2=0 DirComp3=0} lande_g_factor=2
  NdFe35 South: permittivity=1 permeability=1.0997785 conductivity=625000 magnetic_coercivity{Magnitude=-890000A_per_meter DirComp1=0 DirComp2=0 DirComp3=1} lande_g_factor=2
  NdFe30: permittivity=1 permeability=1.044573 conductivity=625000 magnetic_coercivity{Magnitude=-838000A_per_meter DirComp1=1 DirComp2=0 DirComp3=0} lande_g_factor=2
  NdFe52 (Project#51): permittivity=1 permeability=1.0997785 conductivity=625000 magnetic_coercivity{Magnitude=-971000A_per_meter DirComp1=0 DirComp2=0 DirComp3=1} lande_g_factor=2
  copper: permeability=0.999991 conductivity=58000000
  HDPE plastic: permittivity=2.3 dielectric_loss_tangent=0.0005

design Maxwell3DDesign1 (Maxwell 3D, Magnetostatic, model units mm)
geometry:
  Box1 [vacuum] = box(corner=(-200mm, -200mm, -200mm), size=(400mm, 400mm, 400mm))
  magnet, magnet_1, magnet_2, magnet_3 [NdFe52 (Project#51)] = imported_body(H:\2025\ELECTENG 700AB Part IV Project\Simulations\ANSYS\250806_mhdPumpMk3.3.x_t)
  electrode [copper] = imported_body(H:\2025\ELECTENG 700AB Part IV Project\Simulations\ANSYS\250806_mhdPumpMk3.3.x_t)
  magnet_4 [NdFe52 (Project#51)] = imported_body(H:\2025\ELECTENG 700AB Part IV Project\Simulations\ANSYS\250806_mhdPumpMk3.3.x_t)
  1075T34_Top [HDPE plastic] = imported_body(H:\2025\ELECTENG 700AB Part IV Project\Simulations\ANSYS\250806_mhdPumpMk3.3.x_t)
  magnet_5 [NdFe52 (Project#51)] = imported_body(H:\2025\ELECTENG 700AB Part IV Project\Simulations\ANSYS\250806_mhdPumpMk3.3.x_t)
  1075T34_Top_1 [HDPE plastic] = imported_body(H:\2025\ELECTENG 700AB Part IV Project\Simulations\ANSYS\250806_mhdPumpMk3.3.x_t)
  magnet_6 [NdFe52 (Project#51)] = imported_body(H:\2025\ELECTENG 700AB Part IV Project\Simulations\ANSYS\250806_mhdPumpMk3.3.x_t)
  mhdPump [HDPE plastic] = imported_body(H:\2025\ELECTENG 700AB Part IV Project\Simulations\ANSYS\250806_mhdPumpMk3.3.x_t)
  electrode_1 [copper] = imported_body(H:\2025\ELECTENG 700AB Part IV Project\Simulations\ANSYS\250806_mhdPumpMk3.3.x_t)
  magnet_7 [NdFe52 (Project#51)] = imported_body(H:\2025\ELECTENG 700AB Part IV Project\Simulations\ANSYS\250806_mhdPumpMk3.3.x_t)
  mhdPumpMirror [HDPE plastic] = imported_body(H:\2025\ELECTENG 700AB Part IV Project\Simulations\ANSYS\250806_mhdPumpMk3.3.x_t)
  coordinate_system RelativeCS1 = origin=(0mm, 9.85mm, 3mm) x=(1mm, 0mm, 0mm) y=(0mm, 1mm, 0mm)
  FieldSheet [oriented by RelativeCS1] = rectangle(corner=(0mm, 0mm, 0mm), x_size=38mm, y_size=-19.7mm) in RelativeCS1
  FieldSheetChannelAccurate [oriented by RelativeCS1] = rectangle(corner=(9.5mm, 0mm, 0mm), x_size=19mm, y_size=-19.7mm) in RelativeCS1
  group 250806_mhdPumpMk33 = magnet, magnet_1, magnet_2, magnet_3, electrode, magnet_4, 1075T34_Top, magnet_5, 1075T34_Top_1, magnet_6, mhdPump, electrode_1, magnet_7, mhdPumpMirror
mesh:
  initial mesh: GlobalCurvilinear{Apply}
setups:
  Solver: Magnetostatic MaximumPasses=10 MinimumPasses=2 MinimumConvergedPasses=1 PercentRefinement=30 PercentError=5 NonLinearResidual=0.001
field plots:
  initialMagField, Vector Plot: B over FieldSheet.face on Solver : LastAdaptive
  accurateMagChannel: B over FieldSheetChannelAccurate.face on Solver : LastAdaptive
